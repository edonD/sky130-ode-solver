* SKY130 Four-Quadrant Analog Multiplier
* Part of the Analog ODE Solver project
*
* Required interface (do not change port order):
*   .subckt multiplier xp xn yp yn outp outn vbias_n vbias_p vcm vdd vss
*
* You design the internals. This is just a placeholder.

.subckt multiplier xp xn yp yn outp outn vbias_n vbias_p vcm vdd vss

* TODO: Design your multiplier here.
* Requirements:
*   - Four-quadrant: Vout ∝ (xp-xn) × (yp-yn)
*   - Linear over ±300mV on both inputs
*   - See specs.json for targets

* Placeholder: dummy (replace with your design)
R1 outp vcm 100k
R2 outn vcm 100k

.ends multiplier
