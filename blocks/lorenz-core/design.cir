* SKY130 Lorenz Core — Three Coupled ODE Channels
* dx/dt = σ(y − x)           σ = 10
* dy/dt = ρ·x − x·z − y     ρ = 28
* dz/dt = x·y − β·z          β = 8/3 ≈ 2.667
*
* Architecture:
*   - Behavioral B-source VCCS for each equation's right-hand side
*   - Real SKY130 integrators (MIM caps + reset switches)
*   - Real SKY130 multipliers for x*z and x*y (realistic nonlinear behavior)
*   - Behavioral buffers isolate integrator outputs from multiplier loading
*
* Interface: .subckt lorenz_core vxp vxn vyp vyn vzp vzn reset vbias_n vbias_p vcm vdd vss

.subckt lorenz_core vxp vxn vyp vyn vzp vzn reset vbias_n vbias_p vcm vdd vss

* ============================================================
* Scaling parameters
* ============================================================
* gm_base sets the time scale: τ_L = C_eff / gm_base
* C_eff ≈ 2.565 pF (differential), so τ_L = 2.565p / 2µ = 1.28 µs
.param gm_base = 2u

* Scale factor a (V per Lorenz unit) — controls attractor amplitude
* x ∈ [-20,20] → Vx ∈ ±200mV with a = 10mV
.param a_scale = 0.014

* Derived Gm values for each Lorenz coefficient
.param gm_sigma = {10 * gm_base}
.param gm_rho   = {33.5 * gm_base}
.param gm_unity = {gm_base}
.param gm_beta  = {3.2 * gm_base}

* Nonlinear coupling: Gm_nl * K_mult = gm_base / a_scale
* K_mult = 1.233 V^-1 → gm_nl = gm_base / (a_scale * 1.233)
.param gm_nl = {gm_base / (a_scale * 1.233)}

* Multiplier bias — increased from 0.64 for PVT robustness at slow corners
.param vbn_mult = 0.70

* ============================================================
* Voltage buffers (isolate integrator caps from multiplier loading)
* ============================================================
Ebuf_xp  bxp  0  vxp 0  1.0
Ebuf_xn  bxn  0  vxn 0  1.0
Ebuf_yp  byp  0  vyp 0  1.0
Ebuf_yn  byn  0  vyn 0  1.0
Ebuf_zp  bzp  0  vzp 0  1.0
Ebuf_zn  bzn  0  vzn 0  1.0

* ============================================================
* Multipliers (real SKY130 Gilbert cells)
* ============================================================
* x*z for y-channel nonlinear term
XMult_xz  bxp bxn  bzp bzn  mxzp mxzn  vbn_m  vbias_p vcm vdd vss  multiplier
* x*y for z-channel nonlinear term
XMult_xy  bxp bxn  byp byn  mxyp mxyn  vbn_m2 vbias_p vcm vdd vss  multiplier
Vbnm   vbn_m  0 DC {vbn_mult}
Vbnm2  vbn_m2 0 DC {vbn_mult}

* ============================================================
* X Channel: dx/dt = σ(y − x)
* ============================================================
* Current INTO xn1 (positive side) charges cap → vxp rises
* Current OUT of xn2 (negative side) discharges cap → vxn falls
* SPICE: B n+ n- I=val → positive val = current from n+ to n-
Bx_pos  vcm xn1  I = {gm_sigma} * (V(vyp,vyn) - V(vxp,vxn)) / 2
Bx_neg  xn2 vcm  I = {gm_sigma} * (V(vyp,vyn) - V(vxp,vxn)) / 2

XIntX  xn1 xn2  vxp vxn  reset vbias_n vcm vdd vss  integrator

* ============================================================
* Y Channel: dy/dt = ρ·x − x·z − y
* ============================================================
By_pos  vcm yn1  I = ({gm_rho} * V(vxp,vxn) - {gm_nl} * V(mxzp,mxzn) - {gm_unity} * V(vyp,vyn)) / 2
By_neg  yn2 vcm  I = ({gm_rho} * V(vxp,vxn) - {gm_nl} * V(mxzp,mxzn) - {gm_unity} * V(vyp,vyn)) / 2

XIntY  yn1 yn2  vyp vyn  reset vbias_n vcm vdd vss  integrator

* ============================================================
* Z Channel: dz/dt = x·y − β·z
* ============================================================
Bz_pos  vcm zn1  I = ({gm_nl} * V(mxyp,mxyn) - {gm_beta} * V(vzp,vzn)) / 2
Bz_neg  zn2 vcm  I = ({gm_nl} * V(mxyp,mxyn) - {gm_beta} * V(vzp,vzn)) / 2

XIntZ  zn1 zn2  vzp vzn  reset vbias_n vcm vdd vss  integrator

.ends lorenz_core
