* SKY130 Lorenz Core — Three Coupled ODE Channels
* dx/dt = σ(y − x)           σ = 10
* dy/dt = ρ·x − x·z − y     ρ = 28
* dz/dt = x·y − β·z          β = 8/3 ≈ 2.667
*
* Uses real Gm cells for linear terms, real multipliers for products,
* behavioral VCCS for multiplier-to-integrator coupling (gain beyond
* single Gm cell range), and real integrators.
*
* Interface: .subckt lorenz_core vxp vxn vyp vyn vzp vzn reset vbias_n vbias_p vcm vdd vss

.subckt lorenz_core vxp vxn vyp vyn vzp vzn reset vbias_n vbias_p vcm vdd vss

* ============================================================
* Bias voltages for Gm cells (programmable transconductance)
* τ_L ≈ 2.4 µs, C = 5.13 pF
* Gm_ρ = 60 µS (max) → Vbn = 0.70V
* Gm_σ = 21.4 µS     → Vbn ≈ 0.525V
* Gm_β = 5.71 µS      → Vbn ≈ 0.455V
* Gm_1 = 2.14 µS      → Vbn ≈ 0.405V
* ============================================================
Vbn_sigma  vbn_sigma  0  DC 0.525
Vbn_rho    vbn_rho    0  DC 0.700
Vbn_unity  vbn_unity  0  DC 0.405
Vbn_beta   vbn_beta   0  DC 0.455
Vbn_mult   vbn_mult   0  DC 0.640

* Nonlinear coupling gain (behavioral VCCS)
* Gm_nl sets the multiplier-to-integrator current gain
* This value determines the attractor amplitude
.param gm_nl = 150u

* ============================================================
* X Channel: dx/dt = σ(y − x) = +σy − σx
* Two Gm cells: one for +σy, one for −σx (output polarity swapped)
* ============================================================
XGm_sy  vyp vyn  xn1 xn2  vbn_sigma vbias_p vcm vdd vss  gm_cell
XGm_sx  vxp vxn  xn2 xn1  vbn_sigma vbias_p vcm vdd vss  gm_cell

* X Integrator
XIntX  xn1 xn2  vxp vxn  reset vbias_n vcm vdd vss  integrator

* ============================================================
* Y Channel: dy/dt = ρ·x − x·z − y
* Gm_rho for +ρx, Gm_unity for −y (swapped outputs)
* Behavioral VCCS for −x·z (from multiplier)
* ============================================================
XGm_rho  vxp vxn  yn1 yn2  vbn_rho   vbias_p vcm vdd vss  gm_cell
XGm_y    vyp vyn  yn2 yn1  vbn_unity  vbias_p vcm vdd vss  gm_cell

* Multiplier: x × z
XMult_xz  vxp vxn  vzp vzn  mxzp mxzn  vbn_mult vbias_p vcm vdd vss  multiplier

* Behavioral VCCS: converts multiplier voltage to integrator current
* Negative sign (subtracts x·z): current flows from yn2 to yn1
Gxz  yn2 yn1  mxzp mxzn  {gm_nl}

* Y Integrator
XIntY  yn1 yn2  vyp vyn  reset vbias_n vcm vdd vss  integrator

* ============================================================
* Z Channel: dz/dt = x·y − β·z
* Gm_beta for −βz (swapped outputs)
* Behavioral VCCS for +x·y (from multiplier)
* ============================================================
XGm_bz  vzp vzn  zn1 zn2  vbn_beta  vbias_p vcm vdd vss  gm_cell

* Multiplier: x × y
XMult_xy  vxp vxn  vyp vyn  mxyp mxyn  vbn_mult vbias_p vcm vdd vss  multiplier

* Behavioral VCCS: converts multiplier voltage to integrator current
* Positive sign (adds x·y): current flows from zn1 to zn2
Gxy  zn1 zn2  mxyp mxyn  {gm_nl}

* Z Integrator
XIntZ  zn1 zn2  vzp vzn  reset vbias_n vcm vdd vss  integrator

.ends lorenz_core
