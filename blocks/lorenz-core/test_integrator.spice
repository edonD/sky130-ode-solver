* Test: G-source driving real integrator
.title Integrator Test

.lib "sky130_models/sky130.lib.spice" tt
.include "../integrator/design.cir"

Vdd vdd 0 DC 1.8
Vss vss 0 DC 0
Vcm vcm 0 DC 0.9
Vbn vbias_n 0 DC 0.6
Vrst reset 0 PULSE(1.8 0 100n 1n 1n 100u 200u)

* Real integrator
XInt1 inp inn outp outn reset vbias_n vcm vdd vss integrator

* Constant differential current source: 5µA into inp, out of inn
* This should create a linear ramp
Itest_p inp vcm DC 5u
Itest_n vcm inn DC 5u

.option method=gear reltol=1e-4

.control
set filetype=ascii
tran 1n 10u uic
wrdata integ_test.txt V(outp) V(outn) V(inp) V(inn) V(reset)
quit
.endc

.end
