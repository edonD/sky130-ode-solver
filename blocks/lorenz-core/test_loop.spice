* Test: Linearized Lorenz (no nonlinear terms) with real integrators
* Should show exponential growth from perturbation
.title Linearized Lorenz Test

.lib "sky130_models/sky130.lib.spice" tt
.include "../integrator/design.cir"

Vdd vdd 0 DC 1.8
Vss vss 0 DC 0
Vcm vcm 0 DC 0.9
Vbn vbias_n 0 DC 0.6
Vrst reset 0 PULSE(1.8 0 200n 1n 1n 100u 200u)

.param gm_ref = 5u

* X channel: dx/dt = sigma(y - x), sigma=10
Gsy xn1 xn2 vyp vyn {10*gm_ref}
Gsx xn2 xn1 vxp vxn {10*gm_ref}
XIntX xn1 xn2 vxp vxn reset vbias_n vcm vdd vss integrator

* Y channel: dy/dt = rho*x - y, rho=28
Grho yn1 yn2 vxp vxn {28*gm_ref}
Gy yn2 yn1 vyp vyn {1*gm_ref}
XIntY yn1 yn2 vyp vyn reset vbias_n vcm vdd vss integrator

* Perturbation: 5uA differential on X for 50ns after reset release
Ipert1 vxp vcm PULSE(0 2.5u 210n 1n 1n 50n 1)
Ipert2 vcm vxn PULSE(0 2.5u 210n 1n 1n 50n 1)

.option method=gear reltol=1e-4 abstol=1e-12

.control
set filetype=ascii
tran 0.5n 2u uic
wrdata loop_test.txt V(vxp) V(vxn) V(vyp) V(vyn) V(xn1) V(xn2)
quit
.endc

.end
