* Transconductance BW
.lib "sky130_models/sky130.lib.spice" tt
.temp 24

.subckt gm_cell inp inn outp outn vbias_n vbias_p vcm vdd vss

XM1 outn inp s1 vss sky130_fd_pr__nfet_01v8 W=3.9093188091606675e-05 L=1.5e-07
XM2 outp inn s2 vss sky130_fd_pr__nfet_01v8 W=3.9093188091606675e-05 L=1.5e-07

Rs1 s1 ntail 21324.250574744725
Rs2 s2 ntail 21324.250574744725

XMT ntail vbias_n vss vss sky130_fd_pr__nfet_01v8 W=7.810493693075388e-05 L=6.344503488403658e-07

XMP1 outn pcm vdd vdd sky130_fd_pr__pfet_01v8 W=3.0674918392169366e-05 L=8.556040977427018e-07
XMP2 outp pcm vdd vdd sky130_fd_pr__pfet_01v8 W=3.0674918392169366e-05 L=8.556040977427018e-07

Ecmfb pcm 0 VALUE={{V(vbias_p) + 50*((V(outp)+V(outn))/2 - V(vcm))}}

.ends gm_cell

Xdut inp inn outp outn vbias_n vbias_p vcm vdd vss gm_cell
Vdd vdd 0 1.8
Vss vss 0 0
Vcm vcm 0 0.9
Vbias_n vbias_n 0 0.6
Vbias_p vbias_p 0 1.2000000000000002
Vinp inp 0 dc 0.9 ac 0.5
Vinn inn 0 dc 0.9 ac -0.5
* Force output to VCM to measure short-circuit current (Gm * Vin)
Voutp outp 0 dc 0.9
Voutn outn 0 dc 0.9
.ac dec 50 1k 10g
.control
run
* Differential output current = i(Voutp) - i(Voutn)
let idiff = i(Voutp) - i(Voutn)
let gm_mag = db(idiff)
wrdata _gm_bw.dat gm_mag
.endc
.end
