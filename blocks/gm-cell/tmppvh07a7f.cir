* Gm Measurement (loaded)
.lib "sky130_models/sky130.lib.spice" tt
.temp 24

.subckt gm_cell inp inn outp outn vbias_n vbias_p vcm vdd vss

XM1 outn inp s1 vss sky130_fd_pr__nfet_01v8 W=5.926750425242785e-06 L=1.8949065817226455e-07
XM2 outp inn s2 vss sky130_fd_pr__nfet_01v8 W=5.926750425242785e-06 L=1.8949065817226455e-07

Rs1 s1 ntail 26158.671334942985
Rs2 s2 ntail 26158.671334942985

XMT ntail vbias_n vss vss sky130_fd_pr__nfet_01v8 W=6.485268172525629e-05 L=1.8208662663923006e-06

XMP1 outn pcm vdd vdd sky130_fd_pr__pfet_01v8 W=1.8658607099011826e-05 L=2.0334892249375645e-07
XMP2 outp pcm vdd vdd sky130_fd_pr__pfet_01v8 W=1.8658607099011826e-05 L=2.0334892249375645e-07

Ecmfb pcm 0 VALUE={{V(vbias_p) + 50*((V(outp)+V(outn))/2 - V(vcm))}}

.ends gm_cell

Xdut inp inn outp outn vbias_n vbias_p vcm vdd vss gm_cell
Vdd vdd 0 1.8
Vss vss 0 0
Vcm vcm 0 0.9
Vbias_n vbias_n 0 0.6
Vbias_p vbias_p 0 1.2000000000000002

Vdiff vd 0 0
Einp inp 0 VALUE={V(vcm) + V(vd)/2}
Einn inn 0 VALUE={V(vcm) - V(vd)/2}

Rload outp outn 10000

.dc Vdiff -0.005 0.005 0.0001

.control
run
let vout = v(outp) - v(outn)
wrdata _gm_loaded.dat vout
.endc
.end
