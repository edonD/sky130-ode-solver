* SKY130 Programmable OTA (Gm Cell) — Optimized
* Source-degenerated NMOS diff pair + PMOS loads + ideal CMFB
*
* Required interface:
*   .subckt gm_cell inp inn outp outn vbias_n vbias_p vcm vdd vss

.subckt gm_cell inp inn outp outn vbias_n vbias_p vcm vdd vss

* Optimized parameters
.param W_in=3.5e-05
.param L_in=1.5e-06
.param W_load=2e-05
.param L_load=4e-06
.param W_tail=9e-05
.param L_tail=5e-07
.param Rs_deg=4800

XM1 outn inp s1 vss sky130_fd_pr__nfet_01v8 W={W_in} L={L_in}
XM2 outp inn s2 vss sky130_fd_pr__nfet_01v8 W={W_in} L={L_in}

Rs1 s1 ntail {Rs_deg}
Rs2 s2 ntail {Rs_deg}

XMT ntail vbias_n vss vss sky130_fd_pr__nfet_01v8 W={W_tail} L={L_tail}

XMP1 outn pcm vdd vdd sky130_fd_pr__pfet_01v8 W={W_load} L={L_load}
XMP2 outp pcm vdd vdd sky130_fd_pr__pfet_01v8 W={W_load} L={L_load}

* Common-mode feedback (ideal behavioral with RC filter for stability)
Ecmfb pcm_int 0 VALUE={V(vbias_p) + 20*((V(outp)+V(outn))/2 - V(vcm))}
Rcmfb pcm_int pcm 1k
Ccmfb pcm 0 10p

.ends gm_cell
