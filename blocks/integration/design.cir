* SKY130 Analog ODE Solver — Full Integration (Tapeout-Ready)
* Complete Lorenz attractor analog computer with REAL bias generation,
* REAL output buffers, and REAL startup circuit.
* ZERO behavioral E-sources or B-sources at the integration level.
*
* Top-level interface:
*   .subckt ode_solver vxp_buf vxn_buf vyp_buf vyn_buf vzp_buf vzn_buf reset vdd vss

.include ../lorenz-core/design.cir
.include ../integrator/design.cir
.include ../multiplier/design.cir

.subckt ode_solver vxp_buf vxn_buf vyp_buf vyn_buf vzp_buf vzn_buf reset vdd vss

* ============================================================
* Bias Generation — VCM (low-impedance resistive divider + decoupling)
* ============================================================
* Two matched 1kΩ resistors: VCM = VDD/2 = 0.9V
* Source impedance = 500Ω (parallel combination)
* 100pF decoupling cap provides charge reservoir & filters noise
* Power: VDD²/(2×1k) = 1.62 mW
Rvcm_hi vdd vcm 1k
Rvcm_lo vcm vss 1k
Cvcm_dec vcm vss 100p

* ============================================================
* Bias Generation — NMOS bias (vbias_n)
* ============================================================
* Diode-connected NMOS + pull-up resistor from VDD
* Self-biasing: Vbias_n = Vgs = Vth + Vov ≈ 0.55-0.65V
* Current ≈ (1.8 − 0.6) / 200kΩ ≈ 6 µA
* Bypass cap for stability
Rbn_pull vdd vbias_n 200k
Xbn_diode vbias_n vbias_n vss vss sky130_fd_pr__nfet_01v8 W=1u L=1u
Cbn_dec vbias_n vss 5p

* ============================================================
* Bias Generation — PMOS bias (vbias_p)
* ============================================================
* Resistive divider to ~VDD/2
* (Multiplier subcircuit pin exists but is unused internally;
*  valid voltage prevents floating-node issues)
Rbp_hi vdd vbias_p 50k
Rbp_lo vbias_p vss 50k
Cbp_dec vbias_p vss 5p

* ============================================================
* Lorenz Core Instance
* ============================================================
XCore vxp vxn vyp vyn vzp vzn reset vbias_n vbias_p vcm vdd vss lorenz_core

* ============================================================
* Startup Perturbation — RC One-Shot + NMOS Switch
* ============================================================
* RC one-shot pulse generator:
* During reset (HIGH): kick_gate charges to VDD through Rkick_rc
* When reset falls: kick_gate decays through Rkick_rc toward 0V
* Time constant = Rkick_rc × Ckick_rc = 100kΩ × 0.2pF = 20ns
* While kick_gate > Vth (~0.4V): NMOS switch is ON
* Current path: VDD → NMOS switch → Rkick_lim → vxp
* I ≈ (VDD − VCM) / Rkick_lim ≈ 0.9V / 900kΩ ≈ 1µA for ~20ns
* This injects ~20fC into the x integrator cap (5pF) → ΔVxp ≈ 4mV
Rkick_rc reset kick_gate 100k
Ckick_rc kick_gate vss 0.2p
Xkick_sw vdd kick_gate kick_mid vss sky130_fd_pr__nfet_01v8 W=1u L=0.5u
Rkick_lim kick_mid vxp 900k

* ============================================================
* Output Buffers — NMOS Source Followers
* ============================================================
* Each buffer: NMOS follower (common-drain) + NMOS current source
* Follower: drain=VDD, gate=core_output, source=buf_output
* Current source: drain=buf_output, gate=vbias_n, source=VSS
* Voltage gain ≈ gm/(gm+gmb+gds) ≈ 0.85-0.95
* DC level shift ≈ −Vgs (cancels in differential measurement)
* Wide followers (W=10u) for low Vgs and better linearity
* Pin order: d g s b

* X+ buffer
Xbuf_xp_f vdd vxp vxp_buf vss sky130_fd_pr__nfet_01v8 W=10u L=0.5u
Xbuf_xp_cs vxp_buf vbias_n vss vss sky130_fd_pr__nfet_01v8 W=2u L=1u

* X− buffer
Xbuf_xn_f vdd vxn vxn_buf vss sky130_fd_pr__nfet_01v8 W=10u L=0.5u
Xbuf_xn_cs vxn_buf vbias_n vss vss sky130_fd_pr__nfet_01v8 W=2u L=1u

* Y+ buffer
Xbuf_yp_f vdd vyp vyp_buf vss sky130_fd_pr__nfet_01v8 W=10u L=0.5u
Xbuf_yp_cs vyp_buf vbias_n vss vss sky130_fd_pr__nfet_01v8 W=2u L=1u

* Y− buffer
Xbuf_yn_f vdd vyn vyn_buf vss sky130_fd_pr__nfet_01v8 W=10u L=0.5u
Xbuf_yn_cs vyn_buf vbias_n vss vss sky130_fd_pr__nfet_01v8 W=2u L=1u

* Z+ buffer
Xbuf_zp_f vdd vzp vzp_buf vss sky130_fd_pr__nfet_01v8 W=10u L=0.5u
Xbuf_zp_cs vzp_buf vbias_n vss vss sky130_fd_pr__nfet_01v8 W=2u L=1u

* Z− buffer
Xbuf_zn_f vdd vzn vzn_buf vss sky130_fd_pr__nfet_01v8 W=10u L=0.5u
Xbuf_zn_cs vzn_buf vbias_n vss vss sky130_fd_pr__nfet_01v8 W=2u L=1u

.ends ode_solver
