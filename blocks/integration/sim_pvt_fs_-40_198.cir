* Full Integration Simulation — fs/-40C/1.98V
.lib "sky130_models/sky130.lib.spice" fs

.include design.cir

* Top-level instantiation
XTop vxp_buf vxn_buf vyp_buf vyn_buf vzp_buf vzn_buf reset vdd vss ode_solver

* Supply
Vdd vdd 0 DC 1.98
Vss vss 0 DC 0

* Reset: high for 500ns, then low
Vrst reset 0 DC 0 PWL(0 1.98 500n 1.98 501n 0)

* Transient
.tran 1n 80000n 0 1n
.options method=gear maxord=3

* Save data
.control
run
wrdata data_pvt_fs_-40_198.txt v(vxp_buf) v(vxn_buf) v(vyp_buf) v(vyn_buf) v(vzp_buf) v(vzn_buf) v(vdd) i(Vdd)
quit
.endc

.end
