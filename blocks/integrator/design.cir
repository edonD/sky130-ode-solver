* SKY130 Gm-C Integrator with Transmission Gate Reset
* Passive integrator: MIM caps + TG reset switches + dummy charge injection cancellation
*
* Interface: .subckt integrator inp inn outp outn reset vbias_n vcm vdd vss

.subckt integrator inp inn outp outn reset vbias_n vcm vdd vss

* Parameters
.param C_mim_w=50e-6 C_mim_l=50e-6
.param W_nsw=2u L_nsw=0.5u
.param W_psw=4u L_psw=0.5u
.param W_dum_n=1u L_dum_n=0.5u
.param W_dum_p=2u L_dum_p=0.5u

* Generate reset_b (inverted reset) for PMOS switch gate
* Simple CMOS inverter for reset_b
XMinv_n reset_b reset vss vss sky130_fd_pr__nfet_01v8 W=0.42u L=0.15u
XMinv_p reset_b reset vdd vdd sky130_fd_pr__pfet_01v8 W=0.84u L=0.15u

* ============================================================
* Positive half: outp node
* ============================================================

* Integration capacitor (MIM cap) - outp to vcm
XCp outp vcm sky130_fd_pr__cap_mim_m3_1 W={C_mim_w} L={C_mim_l}

* Transmission gate reset switch: connects outp to vcm when reset=1
* NMOS: gate=reset, source=vcm, drain=outp
XSWp_n outp vcm reset vss sky130_fd_pr__nfet_01v8 W={W_nsw} L={L_nsw}
* PMOS: gate=reset_b, source=vcm, drain=outp
XSWp_p outp vcm reset_b vdd sky130_fd_pr__pfet_01v8 W={W_psw} L={L_psw}

* Dummy transistors for charge injection cancellation on outp
* Half-size, gate=reset, drain=source=outp (absorb charge injection)
XDp_n outp outp reset vss sky130_fd_pr__nfet_01v8 W={W_dum_n} L={L_dum_n}
XDp_p outp outp reset_b vdd sky130_fd_pr__pfet_01v8 W={W_dum_p} L={L_dum_p}

* ============================================================
* Negative half: outn node
* ============================================================

* Integration capacitor (MIM cap) - outn to vcm
XCn outn vcm sky130_fd_pr__cap_mim_m3_1 W={C_mim_w} L={C_mim_l}

* Transmission gate reset switch: connects outn to vcm when reset=1
XSWn_n outn vcm reset vss sky130_fd_pr__nfet_01v8 W={W_nsw} L={L_nsw}
XSWn_p outn vcm reset_b vdd sky130_fd_pr__pfet_01v8 W={W_psw} L={L_psw}

* Dummy transistors for charge injection cancellation on outn
XDn_n outn outn reset vss sky130_fd_pr__nfet_01v8 W={W_dum_n} L={L_dum_n}
XDn_p outn outn reset_b vdd sky130_fd_pr__pfet_01v8 W={W_dum_p} L={L_dum_p}

* ============================================================
* Input connections: inp and inn connect directly to cap nodes
* Current from upstream OTA flows into outp/outn and integrates on caps
* ============================================================
* The inp/inn are current inputs - they are physically the same nodes
* as outp/outn in the system (OTA output drives integrator cap directly).
* But in our subcircuit interface, we make them separate and connect:
Rinp inp outp 0.1
Rinn inn outn 0.1

.ends integrator
